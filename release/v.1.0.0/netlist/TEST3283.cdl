* TEST3283 schematic netlist for LVS, generated by scripts/lvs_netlist.py from slots.csv.
* Bk_P: left signal pad (PLUS), Bk_M: right signal pad (MINUS) of tile Bk.
.SUBCKT TEST3283
CB1_1 B1_P B1_M cap_cmomi w=2.0e-06 l=2.0e-06 mmin=1 mmax=4 feed=double
CB1_2 B1_P B1_M cap_cmomi w=2.0e-06 l=2.0e-06 mmin=1 mmax=4 feed=double
CB1_3 B1_P B1_M cap_cmomi w=2.0e-06 l=2.0e-06 mmin=1 mmax=4 feed=double
CB1_4 B1_P B1_M cap_cmomi w=2.0e-06 l=2.0e-06 mmin=1 mmax=4 feed=double
CB1_5 B1_P B1_M cap_cmomi w=2.0e-06 l=2.0e-06 mmin=1 mmax=4 feed=double
CB1_6 B1_P B1_M cap_cmomi w=2.0e-06 l=2.0e-06 mmin=1 mmax=4 feed=double
CB1_7 B1_P B1_M cap_cmomi w=2.0e-06 l=2.0e-06 mmin=1 mmax=4 feed=double
CB1_8 B1_P B1_M cap_cmomi w=2.0e-06 l=2.0e-06 mmin=1 mmax=4 feed=double
CB1_9 B1_P B1_M cap_cmomi w=2.0e-06 l=2.0e-06 mmin=1 mmax=4 feed=double
CB1_10 B1_P B1_M cap_cmomi w=2.0e-06 l=2.0e-06 mmin=1 mmax=4 feed=double
CB1_11 B1_P B1_M cap_cmomi w=2.0e-06 l=2.0e-06 mmin=1 mmax=4 feed=double
CB1_12 B1_P B1_M cap_cmomi w=2.0e-06 l=2.0e-06 mmin=1 mmax=4 feed=double
CB1_13 B1_P B1_M cap_cmomi w=2.0e-06 l=2.0e-06 mmin=1 mmax=4 feed=double
CB1_14 B1_P B1_M cap_cmomi w=2.0e-06 l=2.0e-06 mmin=1 mmax=4 feed=double
CB1_15 B1_P B1_M cap_cmomi w=2.0e-06 l=2.0e-06 mmin=1 mmax=4 feed=double
CB1_16 B1_P B1_M cap_cmomi w=2.0e-06 l=2.0e-06 mmin=1 mmax=4 feed=double
CB1_17 B1_P B1_M cap_cmomi w=2.0e-06 l=2.0e-06 mmin=1 mmax=4 feed=double
CB1_18 B1_P B1_M cap_cmomi w=2.0e-06 l=2.0e-06 mmin=1 mmax=4 feed=double
CB1_19 B1_P B1_M cap_cmomi w=2.0e-06 l=2.0e-06 mmin=1 mmax=4 feed=double
CB2_1 B2_P B2_M cap_cmomi w=4.9e-06 l=4.9e-06 mmin=1 mmax=4 feed=double
CB2_2 B2_P B2_M cap_cmomi w=4.9e-06 l=4.9e-06 mmin=1 mmax=4 feed=double
CB2_3 B2_P B2_M cap_cmomi w=4.9e-06 l=4.9e-06 mmin=1 mmax=4 feed=double
CB2_4 B2_P B2_M cap_cmomi w=4.9e-06 l=4.9e-06 mmin=1 mmax=4 feed=double
CB2_5 B2_P B2_M cap_cmomi w=4.9e-06 l=4.9e-06 mmin=1 mmax=4 feed=double
CB2_6 B2_P B2_M cap_cmomi w=4.9e-06 l=4.9e-06 mmin=1 mmax=4 feed=double
CB2_7 B2_P B2_M cap_cmomi w=4.9e-06 l=4.9e-06 mmin=1 mmax=4 feed=double
CB2_8 B2_P B2_M cap_cmomi w=4.9e-06 l=4.9e-06 mmin=1 mmax=4 feed=double
CB2_9 B2_P B2_M cap_cmomi w=4.9e-06 l=4.9e-06 mmin=1 mmax=4 feed=double
CB3_1 B3_P B3_M cap_cmomi w=7.8e-06 l=7.8e-06 mmin=1 mmax=4 feed=double
CB3_2 B3_P B3_M cap_cmomi w=7.8e-06 l=7.8e-06 mmin=1 mmax=4 feed=double
CB3_3 B3_P B3_M cap_cmomi w=7.8e-06 l=7.8e-06 mmin=1 mmax=4 feed=double
CB3_4 B3_P B3_M cap_cmomi w=7.8e-06 l=7.8e-06 mmin=1 mmax=4 feed=double
CB3_5 B3_P B3_M cap_cmomi w=7.8e-06 l=7.8e-06 mmin=1 mmax=4 feed=double
CB4_1 B4_P B4_M cap_cmomi w=10.7e-06 l=10.7e-06 mmin=1 mmax=4 feed=double
CB4_2 B4_P B4_M cap_cmomi w=10.7e-06 l=10.7e-06 mmin=1 mmax=4 feed=double
CB4_3 B4_P B4_M cap_cmomi w=10.7e-06 l=10.7e-06 mmin=1 mmax=4 feed=double
CB4_4 B4_P B4_M cap_cmomi w=10.7e-06 l=10.7e-06 mmin=1 mmax=4 feed=double
CB4_5 B4_P B4_M cap_cmomi w=10.7e-06 l=10.7e-06 mmin=1 mmax=4 feed=double
CB5_1 B5_P B5_M cap_cmomi w=13.6e-06 l=13.6e-06 mmin=1 mmax=4 feed=double
CB5_2 B5_P B5_M cap_cmomi w=13.6e-06 l=13.6e-06 mmin=1 mmax=4 feed=double
CB5_3 B5_P B5_M cap_cmomi w=13.6e-06 l=13.6e-06 mmin=1 mmax=4 feed=double
CB5_4 B5_P B5_M cap_cmomi w=13.6e-06 l=13.6e-06 mmin=1 mmax=4 feed=double
CB5_5 B5_P B5_M cap_cmomi w=13.6e-06 l=13.6e-06 mmin=1 mmax=4 feed=double
CB6_1 B6_P B6_M cap_cmomi w=16.4e-06 l=16.4e-06 mmin=1 mmax=4 feed=double
CB6_2 B6_P B6_M cap_cmomi w=16.4e-06 l=16.4e-06 mmin=1 mmax=4 feed=double
CB6_3 B6_P B6_M cap_cmomi w=16.4e-06 l=16.4e-06 mmin=1 mmax=4 feed=double
CB6_4 B6_P B6_M cap_cmomi w=16.4e-06 l=16.4e-06 mmin=1 mmax=4 feed=double
CB6_5 B6_P B6_M cap_cmomi w=16.4e-06 l=16.4e-06 mmin=1 mmax=4 feed=double
CB7_1 B7_P B7_M cap_cmomi w=22.2e-06 l=22.2e-06 mmin=1 mmax=4 feed=double
CB7_2 B7_P B7_M cap_cmomi w=22.2e-06 l=22.2e-06 mmin=1 mmax=4 feed=double
CB7_3 B7_P B7_M cap_cmomi w=22.2e-06 l=22.2e-06 mmin=1 mmax=4 feed=double
CB7_4 B7_P B7_M cap_cmomi w=22.2e-06 l=22.2e-06 mmin=1 mmax=4 feed=double
CB7_5 B7_P B7_M cap_cmomi w=22.2e-06 l=22.2e-06 mmin=1 mmax=4 feed=double
CB8_1 B8_P B8_M cap_cmomi w=28.0e-06 l=28.0e-06 mmin=1 mmax=4 feed=double
CB9_1 B9_P B9_M cap_cmomi w=36.7e-06 l=36.7e-06 mmin=1 mmax=4 feed=double
CB10_1 B10_P B10_M cap_cmomi w=45.3e-06 l=45.3e-06 mmin=1 mmax=4 feed=double
CB11_1 B11_P B11_M cap_cmomi w=54.0e-06 l=54.0e-06 mmin=1 mmax=4 feed=double
CB12_1 B12_P B12_M cap_cmomi w=62.7e-06 l=62.7e-06 mmin=1 mmax=4 feed=double
CB13_1 B13_P B13_M cap_cmomi w=71.3e-06 l=71.3e-06 mmin=1 mmax=4 feed=double
CB14_1 B14_P B14_M cap_cmomi w=80.0e-06 l=80.0e-06 mmin=1 mmax=4 feed=double
CB15_1 B15_P B15_M cap_cmomi w=80.0e-06 l=2.0e-06 mmin=1 mmax=4 feed=double
CB16_1 B16_P B16_M cap_cmomi w=80.0e-06 l=5.0e-06 mmin=1 mmax=4 feed=double
CB17_1 B17_P B17_M cap_cmomi w=80.0e-06 l=10.0e-06 mmin=1 mmax=4 feed=double
CB18_1 B18_P B18_M cap_cmomi w=80.0e-06 l=20.0e-06 mmin=1 mmax=4 feed=double
CB19_1 B19_P B19_M cap_cmomi w=80.0e-06 l=40.0e-06 mmin=1 mmax=4 feed=double
CB20_1 B20_P B20_M cap_cmomi w=2.0e-06 l=80.0e-06 mmin=1 mmax=4 feed=double
CB21_1 B21_P B21_M cap_cmomi w=5.0e-06 l=80.0e-06 mmin=1 mmax=4 feed=double
CB22_1 B22_P B22_M cap_cmomi w=10.0e-06 l=80.0e-06 mmin=1 mmax=4 feed=double
CB23_1 B23_P B23_M cap_cmomi w=20.0e-06 l=80.0e-06 mmin=1 mmax=4 feed=double
CB24_1 B24_P B24_M cap_cmomi w=10.0e-06 l=10.0e-06 mmin=1 mmax=4 feed=same
CB25_1 B25_P B25_M cap_cmomi w=20.5e-06 l=20.5e-06 mmin=1 mmax=4 feed=same
CB26_1 B26_P B26_M cap_cmomi w=44.0e-06 l=44.0e-06 mmin=1 mmax=4 feed=same
CB27_1 B27_P B27_M cap_cmomi w=80.0e-06 l=80.0e-06 mmin=1 mmax=4 feed=same
CB28_1 B28_P B28_M cap_cmomi w=80.0e-06 l=2.0e-06 mmin=1 mmax=4 feed=same
CB29_1 B29_P B29_M cap_cmomi w=22.2e-06 l=22.2e-06 mmin=3 mmax=4 feed=double
CB30_1 B30_P B30_M cap_cmomi w=80.0e-06 l=80.0e-06 mmin=3 mmax=4 feed=double
CB31_1 B31_P B31_M cap_cmomi w=80.0e-06 l=2.0e-06 mmin=3 mmax=4 feed=double
CB32_1 B32_P B32_M cap_cmomi w=80.0e-06 l=80.0e-06 mmin=3 mmax=4 feed=same
CB34_1 B34_P B34_M cap_cmomi w=10.7e-06 l=10.7e-06 mmin=1 mmax=3 feed=double
CB35_1 B35_P B35_M cap_cmomi w=22.2e-06 l=22.2e-06 mmin=1 mmax=3 feed=double
CB36_1 B36_P B36_M cap_cmomi w=45.3e-06 l=45.3e-06 mmin=1 mmax=3 feed=double
CB37_1 B37_P B37_M cap_cmomi w=80.0e-06 l=80.0e-06 mmin=1 mmax=3 feed=double
CB38_1 B38_P B38_M cap_cmomi w=80.0e-06 l=2.0e-06 mmin=1 mmax=3 feed=double
CB39_1 B39_P B39_M cap_cmomi w=80.0e-06 l=80.0e-06 mmin=1 mmax=3 feed=same
CB40_1 B40_P B40_M cap_cmomi w=10.7e-06 l=10.7e-06 mmin=2 mmax=4 feed=double
CB41_1 B41_P B41_M cap_cmomi w=22.2e-06 l=22.2e-06 mmin=2 mmax=4 feed=double
CB42_1 B42_P B42_M cap_cmomi w=45.3e-06 l=45.3e-06 mmin=2 mmax=4 feed=double
CB43_1 B43_P B43_M cap_cmomi w=80.0e-06 l=80.0e-06 mmin=2 mmax=4 feed=double
CB44_1 B44_P B44_M cap_cmomi w=80.0e-06 l=2.0e-06 mmin=2 mmax=4 feed=double
CB45_1 B45_P B45_M cap_cmomi w=80.0e-06 l=80.0e-06 mmin=2 mmax=4 feed=same
.ENDS TEST3283
